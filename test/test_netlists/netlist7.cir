*
V1 vin 0 1 ac=1
R1 vin v1 1k
R2 v1 0 1k
F1 vb 0 vin v1 0.5
R3 vb 0 1k
C1 vb 0 1uF
.op
.ac dec 10 1 10k
