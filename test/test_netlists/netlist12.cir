*
V1 vin 0 1 ac=1
R1 vin v1 1k ac=0.1
R2 v1 0 1k
.op
.ac dec 10 1 10
