*
    * this is the next voltage source
V1 1 0 10
* first resistor
R1 1 2 1k
    ** second resistor
R2 2 0 1k

* analyses
.OP
.option gmin = 1e-12 abstol= 1e-5 reltol    = 12e-2 aex
