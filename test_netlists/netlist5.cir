*
V1 1 0 1
L1 1 2 3nH
R1 2 3 1k
C1 3 0 1uF
L2 3 0 15nH
.op
.ac
