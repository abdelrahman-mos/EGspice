*
V1 1 0 1
L1 1 2 3nH
R1 2 3 1k
C1 3 0 1uF
L2 3 0 15nH
.op
.ac dec 10 1 10k
.ac oct 8 10k 100k
.ac lin 10 100k 1MEG
.ac
