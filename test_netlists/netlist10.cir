*
V1 vin 0 1
R1 vin vout 1k
R2 vout 0 1k
.dc V1 0 1 0.1
