*
V1 va 0 32V
R1 va vb 2
R3 vb 0 8
R2 vb vc 4
V2 vc 0 20
.op
