*
V1 1 0 1
R1 1 2 1k
C1 2 0 1uF
.op
.ac dec 10 1 10k
