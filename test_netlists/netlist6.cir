*
V1 vin 0 1
G1 vb 0 vin 0 0.5u
R1 vb 0 1k
C1 vb 0 1uF
.op
.ac dec 10 1 10k
