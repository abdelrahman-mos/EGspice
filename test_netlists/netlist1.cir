*
I1 1 0 1u
R2 1 0 1k
R3 1 2 1MEG
R4 2 0 1k
R5 2 3 1k
R6 3 0 1T
R7 3 4 1G
R8 4 0 1k
I9 4 0 1u
.OP
